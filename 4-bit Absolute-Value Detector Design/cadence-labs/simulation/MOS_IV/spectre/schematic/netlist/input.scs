// Design: ee115c/MOS_IV
simulator lang=spectre
global 0
parameters Vin=.5
include "/usr/public.2/ee115c/cadence-labs/gpdk090_v3.4/models/spectre/gpdk090.scs" section=NN

// ee115c/MOS_IV/schematic
NM3 (net014 net012 0 0) gpdk090_nmos1v w=(480n) l=100n m=(1)*(1) simM=(1)*(1)
NM2 (net017 net012 0 0) gpdk090_nmos1v w=(480n) l=100n m=(1)*(1) simM=(1)*(1)
PM2 (net014 0 net011 net011) gpdk090_pmos1v w=(240n) l=100n m=(1)*(1) simM=(1)*(1)
PM0 (net017 net012 net011 net011) gpdk090_pmos1v w=(240n) l=100n m=(1)*(1) simM=(1)*(1)
V1 (net012 net016) vsource dc=Vin type=dc
V0 (net011 0) vsource dc=1 type=dc
simulatorOptions options temp=27
dc dc param=Vin start=0 stop=1 step=0.01
